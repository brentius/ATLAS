ATLAS TIA - 1 nA step with TI OPAx828 PSpice model
* Vendor subcircuit order: IN+ IN- VCC VEE OUT.
* Cextra is tip/PCB/cable capacitance only; the model includes input impedance.
.include vendor/OPAx828.LIB
.param Cfit=0.5p Cstray=0.1p Cextra=15p Ccable=100p Rreceiver=100k
.step param Cfit list 0.2p 0.5p 1p 5p

VPLUS VPLUS_IN 0 15
VMINUS VMINUS_IN 0 -15
R3 VPLUS_IN VP 10
R4 VMINUS_IN VN 10
C2 VP 0 100n
C3 VN 0 100n
C4 VP 0 10u
C5 VN 0 10u

IIN 0 TIP PULSE(0 1n 1m 10n 10n 5m 10m)
Cexternal TIP 0 {Cextra}
R1 TIP RAW 100Meg
C1 TIP RAW {Cfit}
Cfeedback_stray TIP RAW {Cstray}
XU1 0 TIP VP VN RAW OPAx828
R2 RAW OUT 220
Rload OUT 0 {Rreceiver}
Cload OUT 0 {Ccable}

.tran 0 8m 0 1u
.meas tran output_before AVG V(out) FROM=0.5m TO=0.9m
.meas tran output_during AVG V(out) FROM=4m TO=5m
.meas tran output_change PARAM output_during-output_before
.save V(TIP) V(RAW) V(OUT)
.end
