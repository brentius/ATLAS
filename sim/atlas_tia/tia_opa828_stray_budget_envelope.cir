ATLAS TIA - full load/input envelope around high-tolerance stray budget
* C1=0.3p, R1=101Meg; compare 1.27p and 1.28p extra feedback C.
.include vendor/OPAx828.LIB
.param Cstray=1.27p Cextra=0p Ccable=0p Rreceiver=100k
.step param Cstray list 1.27p 1.28p
.step param Cextra list 0p 5p 15p 35p 85p
.step param Ccable list 0p 100p 500p 1000p
.step param Rreceiver list 100k 1T

VPLUS VPLUS_IN 0 15
VMINUS VMINUS_IN 0 -15
R3 VPLUS_IN VP 10
R4 VMINUS_IN VN 10
C2 VP 0 100n
C3 VN 0 100n
C4 VP 0 10u
C5 VN 0 10u

IIN 0 TIP DC 0 AC 1p
Cexternal TIP 0 {Cextra}
R1 TIP RAW 101Meg
C1 TIP RAW 0.3p
Cfeedback_stray TIP RAW {Cstray}
XU1 0 TIP VP VN RAW OPAx828
R2 RAW OUT 220
Rload OUT 0 {Rreceiver}
Cload OUT 0 {Ccable}

.ac dec 100 0.1 10Meg
.save V(OUT)
.end
