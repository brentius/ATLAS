ATLAS TIA - feedback stray sensitivity at high R1 and C1 tolerance
* C1=0.3p is the high end of selected 0.2p +/-0.1p part.
* R1=101Meg is the high end of the assumed +/-1% resistor interval.
* Other values are the slowest case in the existing 640-case sweep.
.include vendor/OPAx828.LIB
.param Cstray=1p
.step param Cstray list 1p 1.2p 1.25p 1.27p 1.275p 1.28p 1.3p 1.5p

VPLUS VPLUS_IN 0 15
VMINUS VMINUS_IN 0 -15
R3 VPLUS_IN VP 10
R4 VMINUS_IN VN 10
C2 VP 0 100n
C3 VN 0 100n
C4 VP 0 10u
C5 VN 0 10u

IIN 0 TIP DC 0 AC 1p
Cexternal TIP 0 0
R1 TIP RAW 101Meg
C1 TIP RAW 0.3p
Cfeedback_stray TIP RAW {Cstray}
XU1 0 TIP VP VN RAW OPAx828
R2 RAW OUT 220
Rload OUT 0 100k
Cload OUT 0 1000p

.ac dec 100 0.1 10Meg
.save V(OUT)
.end
